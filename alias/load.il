;--------------------------
; Program  : virutoso-init(alias/load.il)
; Language : Cadence Skill
; Author   : YEUNGCHIE
;--------------------------

alias( len  length               )
alias( sel  geGetSelSet          )
alias( cv   geGetEditCellView    )
alias( wind hiGetCurrentWindow   )
alias( ciw  hiGetCIWindow        )
alias( fg   leGetEditFigGroup    )
alias( uniq removeListDuplicates )
alias( des  describe             )

; END

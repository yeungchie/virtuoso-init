;--------------------------
; Program  : virutoso-init(alias/load.il)
; Language : Cadence Skill
; Author   : YEUNGCHIE
;--------------------------

alias( sel  geGetSelSet          )
alias( cv   geGetEditCellView    )
alias( wind hiGetCurrentWindow   )
alias( ciw  hiGetCIWindow        )
alias( fg   leGetEditFigGroup    )

; END

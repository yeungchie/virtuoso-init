;--------------------------
; Program  : virutoso-init(alias/load.il)
; Language : Cadence Skill
; Author   : YEUNGCHIE
;--------------------------

alias( sel  geGetSelSet          )
alias( ecv  geGetEditCellView    )
alias( wcv  geGetWindowCellView  )
alias( wind hiGetCurrentWindow   )
alias( ciw  hiGetCIWindow        )
alias( fg   leGetEditFigGroup    )

; END

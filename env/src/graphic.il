;--------------------------
; Program  : virutoso-init(env/src/graphic.il)
; Language : Cadence Skill
; Author   : YEUNGCHIE
;--------------------------

envSetVal("graphic" "maskLayoutDefaultApp"      'string     "Layout XL"     )   ; 新建 Layout 默认进入 XL
envSetVal("graphic" "meshNBThread"              'int        100             )   ; 设置 mesh 线程数 100

; END

;--------------------------
; Program  : virutoso-init(env/src/mpt.il)
; Language : Cadence Skill
; Author   : YEUNGCHIE
;--------------------------

envSetVal("mpt" "unclusteredShapeColor"     'cyclic "asIs"      )   ; 指定未上色图形处理的方式为 asIs

; END

;--------------------------
; Program  : virutoso-init(env/src/dpt.il)
; Language : Cadence Skill
; Author   : YEUNGCHIE
;--------------------------

envSetVal("dpt" "lockedStyle"       'string     "mLine"     )   ; Color Locked 状态下的显示指定为 mLine ，需要提前在 display 中定义

; END
